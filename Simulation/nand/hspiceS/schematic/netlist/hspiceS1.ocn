simulator( 'hspiceS )
createFinalNetlist()
