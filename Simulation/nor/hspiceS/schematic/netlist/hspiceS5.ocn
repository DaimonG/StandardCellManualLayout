simulator( 'hspiceS )
createFinalNetlist()
createFinalNetlist()
